| VSC7442
| Vitesse Semiconductor Corporation
[IBIS ver]   3.2
[File name]   vsc7442_v0_1.ibs
[File Rev]   0.1
[Date]   Jun 04, 2014
[Source]   From silicon level SPICE model.
[Notes]   This IBIS file contains IBIS models for the VSC7442.
   The C_COMP values are estimated.
   The R_pin, C_Pin and L_pin values for 10G and 6G serdes
   (S13-S36) are extracted at 3125MHz. 2G5 and 1G serdes
   (S0-S12) and DDR are extracted at 625MHz. All other signals
   are extracted at 100MHz.
   The component model does NOT include any package parasitics.
   10G and 6G serdes models are only valid for 1Gb operation,
   for higher speeds the AMS model kit must be used instead.
   The file name is longer than the designated 12 chars.
   Currently ignored.
   Version Log
   0.1  Jun 04, 2014   Preliminary release
[Disclaimer] (C) Copyright Vitesse Semiconductor Corporation 2014
                                      All rights reserved
                 Vitesse Semiconductor Corporation hereby grants the
                 user of this IBIS model a non-exclusive, nontransferable
                 license to use this IBIS model under the following terms.
                 Before using this IBIS model, the user should read this
                 license.  If the user does not accept these terms,  the
                 IBIS model should be returned to Vitesse within 30 days.
                 The user is granted this license only to use the
                 IBIS model and is not granted rights to sell, load, rent,
                 lease or license the IBIS model in whole or in part, or in
                 modified form to anyone other than user. User may modify
                 the IBIS model to suit its specific applications but rights
                 to derivative works and such modifications shall belong to
                 Vitesse.
                 This IBIS model is provided on an "AS IS" basis and
                 Vitesse makes absolutely no warranty with respect to the
                 information contained herein.
                 VITESSE DISCLAIMS AND CUSTOMER WAIVES ALL WARRANTIES,
                 EXPRESS OR IMPLIED, INCLUDING WARRANTIES OF MERCHANTABILITY
                 OR FITNESS FOR A PARTICULAR PURPOSE.
                 The entire risk as to quality and performance is with the
                 Customer.
                 ACCORDINGLY, IN NO EVENT SHALL THE COMPANY BE LIABLE FOR
                 ANY DAMAGES, WHETHER IN CONTRACT OR TORT,INCLUDING ANY LOST
                 PROFITS OR OTHER INCIDENTAL,CONSEQUENTIAL, EXEMPLARY, OR
                 PUNITIVE DAMAGES ARISING OUT OF THE USE OR APPLICATION OF
                 THE IBIS MODEL PROVIDED IN THIS PACKAGE.
                 Further, Vitesse reserves the right to make changes without
                 notice to any product herein to improve reliability,
                 function, or design. Vitesse does not convey any license
                 under patent rights or any other intellectual property
                 rights, including those of third parties.
                 Vitesse is not obligated to provide maintenance or support
                 for the licensed IBIS model.
[Copyright]   Vitesse Semiconductor, Inc.
|   Component VSC7442
[Component]   VSC7442
[Manufacturer]   Vitesse Semiconductor Corporation
[Package]
| variable   typ   min   max
R_pkg   0.0000   0.0000   0.0000
L_pkg   0.0000H   0.0000H   0.0000H
C_pkg   0.0000F   0.0000F   0.0000F
[Pin]  signal_name   model_name   R_pin   L_pin   C_pin
A23   CLKOUT2_N   obuf_1g   1.26e+000 1.39e-008 8.10e-013
A22   CLKOUT2_P   obuf_1g   1.33e+000 1.39e-008 8.50e-013
M1   DDR_A0   DDRCMD   1.14e+000 1.26e-008 8.90e-013
T3   DDR_A1   DDRCMD   5.98e-001 6.38e-009 5.46e-013
M3   DDR_A2   DDRCMD   9.83e-001 1.00e-008 8.86e-013
T1   DDR_A3   DDRCMD   8.23e-001 9.27e-009 5.99e-013
N2   DDR_A4   DDRCMD   9.89e-001 1.03e-008 8.19e-013
R4   DDR_A5   DDRCMD   5.67e-001 6.31e-009 5.26e-013
N4   DDR_A6   DDRCMD   7.53e-001 7.92e-009 7.21e-013
R2   DDR_A7   DDRCMD   7.71e-001 8.18e-009 6.95e-013
N1   DDR_A8   DDRCMD   1.11e+000 1.17e-008 9.63e-013
R3   DDR_A9   DDRCMD   7.21e-001 7.57e-009 6.73e-013
T2   DDR_A10   DDRCMD   8.05e-001 8.58e-009 6.15e-013
P3   DDR_A11   DDRCMD   7.36e-001 8.06e-009 5.90e-013
R1   DDR_A12   DDRCMD   8.47e-001 9.35e-009 6.47e-013
P4   DDR_A13   DDRCMD   6.57e-001 6.76e-009 6.13e-013
G2   DDR_A14   DDRCMD   1.53e+000 1.71e-008 1.15e-012
G1   DDR_A15   DDRCMD   1.59e+000 1.76e-008 1.27e-012
U1   DDR_BA0   DDRCMD   8.80e-001 9.57e-009 6.02e-013
T4   DDR_BA1   DDRCMD   4.99e-001 5.57e-009 4.49e-013
U2   DDR_BA2   DDRCMD   7.24e-001 7.67e-009 6.42e-013
P2   DDR_Ck   DDRCMD   9.86e-001 1.02e-008 6.89e-013
U3   DDR_Cke   DDRCMD   6.01e-001 6.33e-009 5.67e-013
P1   DDR_Ckn   DDRCMD   1.05e+000 1.11e-008 6.75e-013
K1   DDR_DQ0   DQ   1.35e+000 1.44e-008 1.10e-012
K4   DDR_DQ1   DQ   8.57e-001 1.00e-008 7.67e-013
L2   DDR_DQ2   DQ   1.14e+000 1.18e-008 9.94e-013
K3   DDR_DQ3   DQ   1.05e+000 1.18e-008 9.30e-013
L4   DDR_DQ4   DQ   8.16e-001 8.91e-009 7.03e-013
L1   DDR_DQ5   DQ   1.30e+000 1.46e-008 9.82e-013
J4   DDR_DQ6   DQ   9.91e-001 1.16e-008 6.59e-013
K2   DDR_DQ7   DQ   1.19e+000 1.27e-008 1.05e-012
W3   DDR_DQ8   DQ   5.90e-001 6.23e-009 5.69e-013
W1   DDR_DQ9   DQ   7.74e-001 8.44e-009 6.61e-013
V3   DDR_DQ10   DQ   5.70e-001 6.01e-009 5.05e-013
V2   DDR_DQ11   DQ   6.54e-001 6.87e-009 6.19e-013
V1   DDR_DQ12   DQ   8.36e-001 8.93e-009 7.00e-013
V4   DDR_DQ13   DQ   5.10e-001 5.56e-009 4.43e-013
W2   DDR_DQ14   DQ   6.35e-001 6.85e-009 5.60e-013
W4   DDR_DQ15   DQ   4.28e-001 4.23e-009 4.90e-013
J3   DDR_LDM   DQ   1.06e+000 1.16e-008 9.50e-013
J1   DDR_LDQS   DQS   1.20e+000 1.41e-008 8.39e-013
J2   DDR_LDQSn   DQS   1.20e+000 1.38e-008 7.71e-013
M4   DDR_nCAS   DDRCMD   8.57e-001 9.07e-009 7.12e-013
H1   DDR_nCS0   DDRCMD   1.65e+000 1.82e-008 1.16e-012
AA1   DDR_nCS1   DDRCMD   1.17e+000 1.25e-008 8.37e-013
L3   DDR_nRAS   DDRCMD   9.36e-001 1.05e-008 7.81e-013
N3   DDR_nWE   DDRCMD   8.19e-001 8.45e-009 7.79e-013
M2   DDR_ODT0   DDRCMD   9.81e-001 1.03e-008 8.38e-013
U4   DDR_ODT1   DDRCMD   5.49e-001 5.62e-009 5.37e-013
Y1   DDR_RExt   NC   3.10e-001 8.69e-009 5.77e-013
Y2   DDR_UDM   DQ   6.41e-001 6.97e-009 5.46e-013
Y3   DDR_UDQS   DQS   6.79e-001 6.76e-009 5.24e-013
Y4   DDR_UDQSn   DQS   6.65e-001 6.43e-009 4.32e-013
AB2   DDR_Vref   NC   4.00e-001 1.08e-008 9.32e-013
A10   GPIO_0   pru16sdgz   5.15e-001 1.32e-008 1.01e-012
B10   GPIO_1   pru16sdgz   6.80e-001 1.31e-008 1.39e-012
C10   GPIO_2   pru16sdgz   6.32e-001 1.16e-008 1.41e-012
D10   GPIO_3   pru16sdgz   4.67e-001 1.17e-008 1.03e-012
A11   GPIO_4   pru16sdgz   5.67e-001 1.26e-008 1.14e-012
B11   GPIO_5   pru16sdgz   4.24e-001 1.17e-008 8.68e-013
C11   GPIO_6   pru16sdgz   5.72e-001 1.10e-008 1.28e-012
D11   GPIO_7   pru16sdgz   5.75e-001 1.09e-008 1.32e-012
A12   GPIO_8   pru16sdgz   8.32e-001 2.19e-008 2.04e-012
B12   GPIO_9   pru16sdgz   7.41e-001 2.04e-008 1.53e-012
A13   GPIO_10   pru16sdgz   4.59e-001 1.09e-008 8.98e-013
B13   GPIO_11   pru16sdgz   3.86e-001 8.91e-009 9.80e-013
C12   GPIO_12   pru16sdgz   3.52e-001 1.02e-008 6.94e-013
D12   GPIO_13   pru16sdgz   4.38e-001 1.01e-008 9.71e-013
A14   GPIO_14   pru16sdgz   3.75e-001 9.80e-009 7.13e-013
B14   GPIO_15   pru16sdgz   2.83e-001 8.46e-009 5.02e-013
D16   GPIO_16   pru16sdgz   9.91e-001 2.41e-008 2.36e-012
C15   GPIO_17   pru16sdgz   7.70e-001 2.17e-008 1.64e-012
D15   GPIO_18   pru16sdgz   8.27e-001 2.26e-008 1.75e-012
D8   GPIO_19   pru16sdgz   6.90e-001 1.36e-008 1.47e-012
A9   GPIO_20   pru16sdgz   7.43e-001 1.49e-008 1.45e-012
B9   GPIO_21   pru16sdgz   6.97e-001 1.35e-008 1.42e-012
C9   GPIO_22   pru16sdgz   5.58e-001 1.29e-008 1.13e-012
D9   GPIO_23   pru16sdgz   6.41e-001 1.25e-008 1.42e-012
C7   GPIO_24   pru16sdgz   7.65e-001 1.50e-008 1.62e-012
D7   GPIO_25   pru16sdgz   5.94e-001 1.45e-008 1.17e-012
C6   GPIO_26   pru16sdgz   7.02e-001 1.76e-008 1.54e-012
D6   GPIO_27   pru16sdgz   5.88e-001 1.68e-008 1.03e-012
C5   GPIO_28   pru16sdgz   9.32e-001 1.76e-008 1.95e-012
D5   GPIO_29   pru16sdgz   7.07e-001 1.64e-008 1.54e-012
C4   GPIO_30   pru16sdgz   8.19e-001 1.81e-008 1.64e-012
D4   GPIO_31   pru16sdgz   9.80e-001 1.95e-008 1.93e-012
B3   GPIO_32   pru16sdgz   9.31e-001 1.97e-008 1.93e-012
C3   GPIO_33   pru16sdgz   1.11e+000 2.08e-008 2.24e-012
B8   GPIO_34   pru16sdgz   6.52e-001 1.42e-008 1.44e-012
A8   GPIO_35   pru16sdgz   7.55e-001 1.55e-008 1.55e-012
A7   GPIO_36   pru16sdgz   6.89e-001 1.62e-008 1.35e-012
C8   GPIO_37   pru16sdgz   6.96e-001 1.42e-008 1.41e-012
H3   GPIO_38   pru16sdgz   7.85e-001 2.12e-008 1.27e-012
H4   GPIO_39   pru16sdgz   8.76e-001 2.02e-008 1.57e-012
B4   GPIO_40   pru16sdgz   9.63e-001 1.93e-008 1.92e-012
A3   GPIO_41   pru16sdgz   1.17e+000 2.27e-008 2.33e-012
B5   GPIO_42   pru16sdgz   8.91e-001 1.84e-008 1.75e-012
A4   GPIO_43   pru16sdgz   1.04e+000 2.05e-008 2.04e-012
B6   GPIO_44   pru16sdgz   8.46e-001 1.68e-008 1.80e-012
A5   GPIO_45   pru16sdgz   7.96e-001 1.89e-008 1.55e-012
B7   GPIO_46   pru16sdgz   7.90e-001 1.63e-008 1.57e-012
A6   GPIO_47   pru16sdgz   9.11e-001 1.83e-008 1.81e-012
A2   GPIO_48   pru16sdgz   1.02e+000 2.14e-008 2.04e-012
B2   GPIO_49   pru16sdgz   1.20e+000 2.31e-008 2.34e-012
B1   GPIO_50   pru16sdgz   1.15e+000 2.41e-008 2.36e-012
C1   GPIO_51   pru16sdgz   1.10e+000 2.31e-008 2.25e-012
C2   GPIO_52   pru16sdgz   1.05e+000 2.20e-008 2.12e-012
D1   GPIO_53   pru16sdgz   1.02e+000 2.12e-008 2.15e-012
D2   GPIO_54   pru16sdgz   1.00e+000 2.00e-008 2.13e-012
D3   GPIO_55   pru16sdgz   9.49e-001 2.05e-008 1.83e-012
B20   GPIO_56   pru16sdgz   3.81e-001 8.48e-009 8.05e-013
A20   GPIO_57   pru16sdgz   3.44e-001 8.05e-009 7.07e-013
B21   GPIO_58   pru16sdgz   3.29e-001 7.63e-009 6.98e-013
A21   GPIO_59   pru16sdgz   4.61e-001 1.03e-008 9.34e-013
D20   GPIO_60   pru16sdgz   2.18e-001 4.51e-009 6.08e-013
C20   GPIO_61   pru16sdgz   2.76e-001 5.74e-009 6.77e-013
D19   GPIO_62   pru16sdgz   2.07e-001 4.39e-009 5.35e-013
C19   GPIO_63   pru16sdgz   2.87e-001 6.37e-009 5.88e-013
N23   HS_TST_N   obuf_1g   1.22e+000 1.33e-008 7.56e-013
N22   HS_TST_P   obuf_1g   1.18e+000 1.30e-008 7.19e-013
A17   JTAG_ICE_nEn   pddsdgz   3.20e-001 8.65e-009 5.53e-013
D23   JTAG_nTRST   pdusdgz   3.23e-001 7.42e-009 8.47e-013
C26   JTAG_TCK   pdusdgz   7.71e-001 1.85e-008 1.29e-012
C24   JTAG_TDI   pdusdgz   4.12e-001 9.39e-009 1.00e-012
C25   JTAG_TDO   pru16sdgz   6.28e-001 1.54e-008 1.13e-012
D22   JTAG_TMS   pdusdgz   2.76e-001 6.07e-009 7.14e-013
AC1   MDC0   MIIM   5.46e-001 1.45e-008 1.02e-012
AB1   MDIO0   MIIM   4.91e-001 1.31e-008 8.43e-013
B19   NC_1   NC
C18   NC_2   NC
B17   NC_3   NC
G3   NC_4   NC
H2   NC_5   NC
AA2   NC_6   NC
AA3   NC_7   NC
AF2   NC_8   NC
B24   NC_9   NC
A19   nReset   pdusdgz   3.38e-001 8.03e-009 7.36e-013
B26   PCIE_RxN   ibuf_6g   1.45e+000 1.60e-008 9.85e-013
B25   PCIE_RxP   ibuf_6g   1.43e+000 1.53e-008 8.79e-013
B23   PCIE_TxN   obuf_6g   1.29e+000 1.36e-008 8.54e-013
B22   PCIE_TxP   obuf_6g   1.26e+000 1.34e-008 8.52e-013
C22   RCVRD_CLK0   pdt24dgz   4.30e-001 1.04e-008 8.57e-013
C23   RCVRD_CLK1   pdt24dgz   3.54e-001 9.09e-009 7.49e-013
C21   RCVRD_CLK2   pdt24dgz   2.73e-001 7.00e-009 6.59e-013
D18   RCVRD_CLK3   pdt24dgz   2.19e-001 5.47e-009 5.37e-013
E1   RefClk2_En   pddsdgz   8.99e-001 2.21e-008 1.77e-012
A25   REFCLK2_N   ibuf_1g   1.12e+000 1.34e-008 6.94e-013
A24   REFCLK2_P   ibuf_1g   1.16e+000 1.33e-008 7.81e-013
E4   RefClk2_Sel0   pddsdgz   9.42e-001 1.93e-008 1.96e-012
E3   RefClk2_Sel1   pddsdgz   9.38e-001 2.01e-008 1.94e-012
E2   RefClk2_Sel2   pddsdgz   9.43e-001 1.99e-008 2.04e-012
M26   REFCLK_N   ibuf_1g   1.38e+000 1.63e-008 7.36e-013
M25   REFCLK_P   ibuf_1g   1.39e+000 1.62e-008 7.59e-013
D17   RefClk_Sel0   pddsdgz   1.61e-001 4.50e-009 3.47e-013
C16   RefClk_Sel1   pddsdgz   2.73e-001 6.43e-009 5.92e-013
C17   RefClk_Sel2   pddsdgz   2.38e-001 6.13e-009 5.26e-013
C13   Reserved_0   NC   2.96e-001 9.55e-009 5.08e-013
F3   Reserved_1   NC   1.29e+000 1.52e-008 1.07e-012
F2   Reserved_2   msd_drv3_40120   1.42e+000 1.66e-008 1.17e-012
F1   Reserved_3   msd_drv3_40120   1.51e+000 1.74e-008 1.21e-012
AA25   Reserved_4   NC   7.87e-001 9.23e-009 4.53e-013
AD3   Reserved_5   NC
AC3   Reserved_6   NC
AF3   Reserved_7   NC
AE3   Reserved_8   NC
AF4   Reserved_9   NC
AE4   Reserved_10   NC
AD4   Reserved_11   NC
AC4   Reserved_12   NC
AD5   Reserved_13   NC
AC5   Reserved_14   NC
AF5   Reserved_15   NC
AE5   Reserved_16   NC
AF6   Reserved_17   NC
AE6   Reserved_18   NC
AD6   Reserved_19   NC
AC6   Reserved_20   NC
AD7   Reserved_21   NC
AC7   Reserved_22   NC
AF7   Reserved_23   NC
AE7   Reserved_24   NC
AF8   Reserved_25   NC
AE8   Reserved_26   NC
AD8   Reserved_27   NC
AC8   Reserved_28   NC
AD9   Reserved_29   NC
AC9   Reserved_30   NC
AF9   Reserved_31   NC
AE9   Reserved_32   NC
AF10   Reserved_33   NC
AE10   Reserved_34   NC
AD10   Reserved_35   NC
AC10   Reserved_36   NC
AD11   Reserved_37   NC
AC11   Reserved_38   NC
AF11   Reserved_39   NC
AE11   Reserved_40   NC
AE12   Reserved_41   NC
AF12   Reserved_42   NC
AD12   Reserved_43   NC
AC12   Reserved_44   NC
AD13   Reserved_45   NC
AC13   Reserved_46   NC
AF13   Reserved_47   NC
AE13   Reserved_48   NC
AE14   Reserved_49   NC
AF14   Reserved_50   NC
AD14   Reserved_51   NC
AC14   Reserved_52   NC
M23   Reserved_78   NC
M22   Reserved_79   NC
L26   Reserved_80   NC
L25   Reserved_81   NC
K25   Reserved_82   NC
K26   Reserved_83   NC
L23   Reserved_84   NC
L22   Reserved_85   NC
K23   Reserved_86   NC
K22   Reserved_87   NC
J26   Reserved_88   NC
J25   Reserved_89   NC
H25   Reserved_90   NC
H26   Reserved_91   NC
J23   Reserved_92   NC
J22   Reserved_93   NC
H23   Reserved_94   NC
H22   Reserved_95   NC
G26   Reserved_96   NC
G25   Reserved_97   NC
F25   Reserved_98   NC
F26   Reserved_99   NC
G23   Reserved_100   NC
G22   Reserved_101   NC
F23   Reserved_102   NC
F22   Reserved_103   NC
E26   Reserved_104   NC
E25   Reserved_105   NC
D25   Reserved_106   NC
D26   Reserved_107   NC
E23   Reserved_108   NC
E22   Reserved_109   NC
AE1   S0_RxN   ibuf_1g   1.14e+000 1.27e-008 7.86e-013
AE2   S0_RxP   ibuf_1g   1.12e+000 1.21e-008 8.23e-013
AD1   S0_TxN   obuf_1g   1.03e+000 1.20e-008 6.67e-013
AD2   S0_TxP   obuf_1g   1.00e+000 1.14e-008 6.91e-013
AF15   S13_RxN   ibuf_6g   6.66e-001 6.94e-009 5.52e-013
AE15   S13_RxP   ibuf_6g   6.56e-001 6.52e-009 5.37e-013
AD15   S13_TxN   obuf_6g   4.73e-001 4.86e-009 3.82e-013
AC15   S13_TxP   obuf_6g   4.31e-001 4.13e-009 3.53e-013
AF16   S14_RxN   ibuf_6g   6.98e-001 7.31e-009 5.70e-013
AE16   S14_RxP   ibuf_6g   6.78e-001 6.61e-009 5.39e-013
AD16   S14_TxN   obuf_6g   4.79e-001 5.03e-009 3.72e-013
AC16   S14_TxP   obuf_6g   4.39e-001 4.25e-009 3.68e-013
AF17   S15_RxN   ibuf_6g   7.24e-001 7.40e-009 5.73e-013
AE17   S15_RxP   ibuf_6g   6.91e-001 6.90e-009 5.42e-013
AD17   S15_TxN   obuf_6g   5.20e-001 5.40e-009 4.21e-013
AC17   S15_TxP   obuf_6g   4.73e-001 4.72e-009 3.58e-013
AF18   S16_RxN   ibuf_6g   7.56e-001 7.97e-009 5.97e-013
AE18   S16_RxP   ibuf_6g   7.35e-001 7.28e-009 5.77e-013
AD18   S16_TxN   obuf_6g   5.39e-001 5.66e-009 4.06e-013
AC18   S16_TxP   obuf_6g   4.97e-001 4.88e-009 4.02e-013
AF19   S17_RxN   ibuf_6g   7.88e-001 8.10e-009 6.15e-013
AE19   S17_RxP   ibuf_6g   7.58e-001 7.62e-009 5.85e-013
AD19   S17_TxN   obuf_6g   6.09e-001 6.37e-009 4.80e-013
AC19   S17_TxP   obuf_6g   5.69e-001 5.65e-009 4.31e-013
AF20   S18_RxN   ibuf_6g   8.43e-001 8.92e-009 6.35e-013
AE20   S18_RxP   ibuf_6g   8.21e-001 8.22e-009 6.09e-013
AD20   S18_TxN   obuf_6g   6.27e-001 6.65e-009 4.62e-013
AC20   S18_TxP   obuf_6g   5.86e-001 5.91e-009 4.59e-013
AF21   S19_RxN   ibuf_6g   8.81e-001 9.18e-009 6.66e-013
AE21   S19_RxP   ibuf_6g   8.47e-001 8.68e-009 6.30e-013
AD21   S19_TxN   obuf_6g   6.98e-001 7.45e-009 5.24e-013
AC21   S19_TxP   obuf_6g   6.53e-001 6.76e-009 4.91e-013
AF22   S20_RxN   ibuf_6g   9.31e-001 1.01e-008 6.52e-013
AE22   S20_RxP   ibuf_6g   9.14e-001 9.37e-009 6.60e-013
AD22   S20_TxN   obuf_6g   6.85e-001 7.47e-009 4.81e-013
AC22   S20_TxP   obuf_6g   6.47e-001 6.79e-009 4.79e-013
AF23   S21_RxN   ibuf_6g   9.56e-001 1.03e-008 7.15e-013
AE23   S21_RxP   ibuf_6g   9.32e-001 9.78e-009 6.88e-013
AD23   S21_TxN   obuf_6g   7.73e-001 8.45e-009 5.53e-013
AC23   S21_TxP   obuf_6g   7.29e-001 7.81e-009 5.34e-013
AF24   S22_RxN   ibuf_6g   1.01e+000 1.09e-008 7.35e-013
AE24   S22_RxP   ibuf_6g   9.83e-001 1.04e-008 7.17e-013
AD24   S22_TxN   obuf_6g   7.53e-001 8.41e-009 5.10e-013
AC24   S22_TxP   obuf_6g   7.15e-001 7.81e-009 5.05e-013
AF25   S23_RxN   ibuf_6g   1.09e+000 1.27e-008 7.06e-013
AE25   S23_RxP   ibuf_6g   1.08e+000 1.20e-008 6.85e-013
AD25   S23_TxN   obuf_6g   8.26e-001 9.41e-009 5.63e-013
AC25   S23_TxP   obuf_6g   8.09e-001 8.86e-009 5.20e-013
AE26   S24_RxN   ibuf_6g   1.16e+000 1.33e-008 8.11e-013
AD26   S24_RxP   ibuf_6g   1.15e+000 1.28e-008 7.69e-013
AC26   S24_TxN   obuf_6g   8.76e-001 1.03e-008 5.56e-013
AB26   S24_TxP   obuf_6g   8.56e-001 9.85e-009 5.76e-013
Y26   S33_RxN   ibuf_10g   8.80e-001 9.63e-009 5.82e-013
Y25   S33_RxP   ibuf_10g   8.95e-001 9.64e-009 6.01e-013
AA23   S33_TxN   NC   4.53e-001 5.86e-009 4.25e-013
AA22   S33_TxP   NC   4.73e-001 5.78e-009 4.14e-013
V26   S34_RxN   ibuf_10g   7.55e-001 8.31e-009 5.24e-013
V25   S34_RxP   ibuf_10g   7.55e-001 8.28e-009 4.43e-013
W23   S34_TxN   NC   5.13e-001 5.71e-009 3.54e-013
W22   S34_TxP   NC   5.28e-001 5.60e-009 3.83e-013
T26   S35_RxN   ibuf_10g   8.12e-001 8.88e-009 5.56e-013
T25   S35_RxP   ibuf_10g   8.12e-001 8.55e-009 5.48e-013
U23   S35_TxN   NC   4.23e-001 4.56e-009 3.37e-013
U22   S35_TxP   NC   4.36e-001 4.33e-009 3.48e-013
P26   S36_RxN   ibuf_10g   8.70e-001 9.33e-009 5.55e-013
P25   S36_RxP   ibuf_10g   8.68e-001 9.17e-009 4.83e-013
R23   S36_TxN   NC   4.08e-001 4.36e-009 3.18e-013
R22   S36_TxP   NC   4.22e-001 4.02e-009 3.04e-013
AB4   SERDES_RExt_0   NC   2.21e-001 6.57e-009 5.73e-013
AB3   SERDES_RExt_1   NC   2.23e-001 7.00e-009 6.36e-013
A15   SI_Clk   pru16sdgz   9.81e-001 2.52e-008 2.39e-012
A16   SI_DI   pdusdgz   8.65e-001 2.48e-008 2.08e-012
B15   SI_DO   pru16sdgz   9.38e-001 2.47e-008 2.10e-012
B16   SI_nCS0   pru16sdgz   9.52e-001 2.48e-008 2.50e-012
A18   ThermDA   NC   3.44e-001 8.28e-009 7.29e-013
B18   ThermDC   NC   2.80e-001 7.07e-009 5.33e-013
C14   VDD_1   POWER
G8   VDD_2   POWER
G9   VDD_3   POWER
G11   VDD_4   POWER
G12   VDD_5   POWER
G15   VDD_6   POWER
G16   VDD_7   POWER
G18   VDD_8   POWER
G19   VDD_9   POWER
H8   VDD_10   POWER
H9   VDD_11   POWER
H11   VDD_12   POWER
H12   VDD_13   POWER
H15   VDD_14   POWER
H16   VDD_15   POWER
H18   VDD_16   POWER
H19   VDD_17   POWER
K8   VDD_18   POWER
K9   VDD_19   POWER
K11   VDD_20   POWER
K12   VDD_21   POWER
K15   VDD_22   POWER
K16   VDD_23   POWER
K18   VDD_24   POWER
K19   VDD_25   POWER
L8   VDD_26   POWER
L9   VDD_27   POWER
L11   VDD_28   POWER
L12   VDD_29   POWER
L15   VDD_30   POWER
L16   VDD_31   POWER
L18   VDD_32   POWER
L19   VDD_33   POWER
P8   VDD_34   POWER
P9   VDD_35   POWER
P11   VDD_36   POWER
P12   VDD_37   POWER
P15   VDD_38   POWER
P16   VDD_39   POWER
P18   VDD_40   POWER
P19   VDD_41   POWER
R8   VDD_42   POWER
R9   VDD_43   POWER
R11   VDD_44   POWER
R12   VDD_45   POWER
R15   VDD_46   POWER
R16   VDD_47   POWER
R18   VDD_48   POWER
R19   VDD_49   POWER
U8   VDD_50   POWER
U9   VDD_51   POWER
U11   VDD_52   POWER
U12   VDD_53   POWER
U15   VDD_54   POWER
U16   VDD_55   POWER
U18   VDD_56   POWER
U19   VDD_57   POWER
V8   VDD_58   POWER
V9   VDD_59   POWER
V11   VDD_60   POWER
V12   VDD_61   POWER
V15   VDD_62   POWER
V16   VDD_63   POWER
V18   VDD_64   POWER
V19   VDD_65   POWER
U20   VDD_A_1   POWER
V20   VDD_A_2   POWER
W8   VDD_A_3   POWER
W9   VDD_A_4   POWER
W11   VDD_A_5   POWER
W12   VDD_A_6   POWER
W15   VDD_A_7   POWER
W16   VDD_A_8   POWER
W18   VDD_A_9   POWER
W19   VDD_A_10   POWER
Y8   VDD_A_11   POWER
Y9   VDD_A_12   POWER
Y11   VDD_A_13   POWER
Y12   VDD_A_14   POWER
Y15   VDD_A_15   POWER
Y16   VDD_A_16   POWER
Y18   VDD_A_17   POWER
Y19   VDD_A_18   POWER
P22   VDD_HS_1   POWER
P23   VDD_HS_2   POWER
T22   VDD_HS_3   POWER
T23   VDD_HS_4   POWER
V22   VDD_HS_5   POWER
V23   VDD_HS_6   POWER
Y22   VDD_HS_7   POWER
Y23   VDD_HS_8   POWER
D21   VDD_IO_1   POWER
E6   VDD_IO_2   POWER
E8   VDD_IO_3   POWER
E9   VDD_IO_4   POWER
E11   VDD_IO_5   POWER
E12   VDD_IO_6   POWER
E15   VDD_IO_7   POWER
E16   VDD_IO_8   POWER
E20   VDD_IO_9   POWER
E21   VDD_IO_10   POWER
F8   VDD_IO_11   POWER
F9   VDD_IO_12   POWER
F11   VDD_IO_13   POWER
F12   VDD_IO_14   POWER
F15   VDD_IO_15   POWER
F16   VDD_IO_16   POWER
F20   VDD_IO_17   POWER
F21   VDD_IO_18   POWER
G5   VDD_IO_19   POWER
G6   VDD_IO_20   POWER
H5   VDD_IO_21   POWER
H6   VDD_IO_22   POWER
K5   VDD_IODDR_1   POWER
K6   VDD_IODDR_2   POWER
L5   VDD_IODDR_3   POWER
L6   VDD_IODDR_4   POWER
P5   VDD_IODDR_5   POWER
P6   VDD_IODDR_6   POWER
R5   VDD_IODDR_7   POWER
R6   VDD_IODDR_8   POWER
U5   VDD_IODDR_9   POWER
U6   VDD_IODDR_10   POWER
V5   VDD_IODDR_11   POWER
V6   VDD_IODDR_12   POWER
Y5   VDD_IODDR_13   POWER
Y6   VDD_IODDR_14   POWER
AC2   VDD_IOMIIM0   POWER   5.42e-001 1.38e-008 1.29e-012
W20   VDD_ref25_0   POWER
Y20   VDD_ref25_1   POWER
AA20   VDD_ref25_2   POWER
AA8   VDD_S_1   POWER
AA9   VDD_S_2   POWER
AA11   VDD_S_3   POWER
AA12   VDD_S_4   POWER
AB8   VDD_S_5   POWER
AB9   VDD_S_6   POWER
AB11   VDD_S_7   POWER
AB12   VDD_S_8   POWER
P20   VDD_V1_1   POWER
P21   VDD_V1_2   POWER
R20   VDD_V1_3   POWER
R21   VDD_V1_4   POWER
U21   VDD_V1_5   POWER
V21   VDD_V1_6   POWER
AA15   VDD_V1_7   POWER
AA16   VDD_V1_8   POWER
AA18   VDD_V1_9   POWER
AA19   VDD_V1_10   POWER
AB15   VDD_V1_11   POWER
AB16   VDD_V1_12   POWER
AB18   VDD_V1_13   POWER
AB19   VDD_V1_14   POWER
G20   VDD_V2_1   POWER
G21   VDD_V2_2   POWER
H20   VDD_V2_3   POWER
H21   VDD_V2_4   POWER
K20   VDD_V2_5   POWER
K21   VDD_V2_6   POWER
L20   VDD_V2_7   POWER
L21   VDD_V2_8   POWER
D13   VSS_1   GND
D14   VSS_2   GND
D24   VSS_3   GND
E5   VSS_4   GND
E7   VSS_5   GND
E10   VSS_6   GND
E13   VSS_7   GND
E14   VSS_8   GND
E17   VSS_9   GND
E18   VSS_10   GND
E19   VSS_11   GND
E24   VSS_12   GND
F4   VSS_13   GND
F5   VSS_14   GND
F6   VSS_15   GND
F7   VSS_16   GND
F10   VSS_17   GND
F13   VSS_18   GND
F14   VSS_19   GND
F17   VSS_20   GND
F18   VSS_21   GND
F19   VSS_22   GND
F24   VSS_23   GND
G4   VSS_24   GND
G7   VSS_25   GND
G10   VSS_26   GND
G13   VSS_27   GND
G14   VSS_28   GND
G17   VSS_29   GND
G24   VSS_30   GND
H7   VSS_31   GND
H10   VSS_32   GND
H13   VSS_33   GND
H14   VSS_34   GND
H17   VSS_35   GND
H24   VSS_36   GND
J5   VSS_37   GND
J6   VSS_38   GND
J7   VSS_39   GND
J8   VSS_40   GND
J9   VSS_41   GND
J10   VSS_42   GND
J11   VSS_43   GND
J12   VSS_44   GND
J13   VSS_45   GND
J14   VSS_46   GND
J15   VSS_47   GND
J16   VSS_48   GND
J17   VSS_49   GND
J18   VSS_50   GND
J19   VSS_51   GND
J20   VSS_52   GND
J21   VSS_53   GND
J24   VSS_54   GND
K7   VSS_55   GND
K10   VSS_56   GND
K13   VSS_57   GND
K14   VSS_58   GND
K17   VSS_59   GND
K24   VSS_60   GND
L7   VSS_61   GND
L10   VSS_62   GND
L13   VSS_63   GND
L14   VSS_64   GND
L17   VSS_65   GND
L24   VSS_66   GND
M5   VSS_67   GND
M6   VSS_68   GND
M7   VSS_69   GND
M8   VSS_70   GND
M9   VSS_71   GND
M10   VSS_72   GND
M11   VSS_73   GND
M12   VSS_74   GND
M13   VSS_75   GND
M14   VSS_76   GND
M15   VSS_77   GND
M16   VSS_78   GND
M17   VSS_79   GND
M18   VSS_80   GND
M19   VSS_81   GND
M20   VSS_82   GND
M21   VSS_83   GND
M24   VSS_84   GND
N5   VSS_85   GND
N6   VSS_86   GND
N7   VSS_87   GND
N8   VSS_88   GND
N9   VSS_89   GND
N10   VSS_90   GND
N11   VSS_91   GND
N12   VSS_92   GND
N13   VSS_93   GND
N14   VSS_94   GND
N15   VSS_95   GND
N16   VSS_96   GND
N17   VSS_97   GND
N18   VSS_98   GND
N19   VSS_99   GND
N20   VSS_100   GND
N21   VSS_101   GND
N24   VSS_102   GND
N25   VSS_103   GND
N26   VSS_104   GND
P7   VSS_105   GND
P10   VSS_106   GND
P13   VSS_107   GND
P14   VSS_108   GND
P17   VSS_109   GND
P24   VSS_110   GND
R10   VSS_111   GND
R7   VSS_112   GND
R13   VSS_113   GND
R14   VSS_114   GND
R17   VSS_115   GND
R24   VSS_116   GND
R25   VSS_117   GND
R26   VSS_118   GND
T5   VSS_119   GND
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[Diff pin] inv_pin   vdiff   tdelay_typ tdelay_min tdelay_max
A22   A23   NA   NA   NA   NA   | CLKOUT2_
P2   P1   NA   NA   NA   NA   | DDR_Ck
J1   J2   NA   NA   NA   NA   | DDR_LDQS
Y3   Y4   NA   NA   NA   NA   | DDR_UDQS
N22   N23   NA   NA   NA   NA   | HS_TST_
B25   B26   NA   NA   NA   NA   | PCIE_Rx
B22   B23   NA   NA   NA   NA   | PCIE_Tx
A24   A25   NA   NA   NA   NA   | REFCLK2_
M25   M26   NA   NA   NA   NA   | REFCLK_
AE2   AE1   NA   NA   NA   NA   | S0_Rx
AD2   AD1   NA   NA   NA   NA   | S0_Tx
AE15   AF15   NA   NA   NA   NA   | S13_Rx
AC15   AD15   NA   NA   NA   NA   | S13_Tx
AE16   AF16   NA   NA   NA   NA   | S14_Rx
AC16   AD16   NA   NA   NA   NA   | S14_Tx
AE17   AF17   NA   NA   NA   NA   | S15_Rx
AC17   AD17   NA   NA   NA   NA   | S15_Tx
AE18   AF18   NA   NA   NA   NA   | S16_Rx
AC18   AD18   NA   NA   NA   NA   | S16_Tx
AE19   AF19   NA   NA   NA   NA   | S17_Rx
AC19   AD19   NA   NA   NA   NA   | S17_Tx
AE20   AF20   NA   NA   NA   NA   | S18_Rx
AC20   AD20   NA   NA   NA   NA   | S18_Tx
AE21   AF21   NA   NA   NA   NA   | S19_Rx
AC21   AD21   NA   NA   NA   NA   | S19_Tx
AE22   AF22   NA   NA   NA   NA   | S20_Rx
AC22   AD22   NA   NA   NA   NA   | S20_Tx
AE23   AF23   NA   NA   NA   NA   | S21_Rx
AC23   AD23   NA   NA   NA   NA   | S21_Tx
AE24   AF24   NA   NA   NA   NA   | S22_Rx
AC24   AD24   NA   NA   NA   NA   | S22_Tx
AE25   AF25   NA   NA   NA   NA   | S23_Rx
AC25   AD25   NA   NA   NA   NA   | S23_Tx
AD26   AE26   NA   NA   NA   NA   | S24_Rx
AB26   AC26   NA   NA   NA   NA   | S24_Tx
Y25   Y26   NA   NA   NA   NA   | S33_Rx
V25   V26   NA   NA   NA   NA   | S34_Rx
T25   T26   NA   NA   NA   NA   | S35_Rx
P25   P26   NA   NA   NA   NA   | S36_Rx
| END [Component]   VSC7442
[Model Selector]   DDRCMD
msd_drv_40150   DDR2 I/O, Zo=40-Ohms, external Rterm=150-Ohms, ODT disabled
msd_drv_4075   DDR2 I/O, Zo=40-Ohms, external Rterm=75-Ohms, ODT disabled
msd_drv_4050   DDR2 I/O, Zo=40-Ohms, external Rterm=50-Ohms, ODT disabled
msd_drv3_40120  DDR3 I/O, Zo=40-Ohms, external Rterm=120-Ohms, ODT disabled
msd_drv3_4060   DDR3 I/O, Zo=40-Ohms, external Rterm=60-Ohms, ODT disabled
msd_drv3_4040   DDR3 I/O, Zo=40-Ohms, external Rterm=40-Ohms, ODT disabled
[Model Selector]   DQS
msdd_drv_40150   DDR2 diff. I/O, Zo=40-Ohms, external Rterm=150-Ohms, ODT off
msdd_drv_4075   DDR2 diff. I/O, Zo=40-Ohms, external Rterm=75-Ohms, ODT off
msdd_drv_4050   DDR2 diff. I/O, Zo=40-Ohms, external Rterm=50-Ohms, ODT off
msdd_rcv_odtoff  DDR2 diff. Input only; On-Die Termination off
msdd_rcv_odt50   DDR2 diff. Input only; On-Die Termination set to 50 Ohms
msdd_rcv_odt75   DDR2 diff. Input only; On-Die Termination set to 75 Ohms
msdd_rcv_odt150  DDR2 diff. Input only; On-Die Termination set to 150 Ohms
msdd_drv3_40120  DDR3 diff. I/O, Zo=40-Ohms, ext. Rterm=120-Ohms, ODT disabled
msdd_drv3_4060   DDR3 diff. I/O, Zo=40-Ohms, ext. Rterm=60-Ohms, ODT disabled
msdd_drv3_4040   DDR3 diff. I/O, Zo=40-Ohms, ext. Rterm=40-Ohms, ODT disabled
msdd_rcv3_odtoff DDR3 diff. Input only; On-Die Termination off
msdd_rcv3_odt40  DDR3 diff. Input only; On-Die Termination set to 40 Ohms
msdd_rcv3_odt60  DDR3 diff. Input only; On-Die Termination set to 60 Ohms
msdd_rcv3_odt120 DDR3 diff. Input only; On-Die Termination set to 120 Ohms
[Model Selector]   DQ
msd_drv_40150   DDR2 I/O, Zo=40-Ohms, external Rterm=150-Ohms, ODT disabled
msd_drv_4075   DDR2 I/O, Zo=40-Ohms, external Rterm=75-Ohms, ODT disabled
msd_drv_4050   DDR2 I/O, Zo=40-Ohms, external Rterm=50-Ohms, ODT disabled
msd_rcv_odtoff  DDR2 Input only; On-Die Termination off
msd_rcv_odt50   DDR2 Input only; On-Die Termination set to 50 Ohms
msd_rcv_odt75   DDR2 Input only; On-Die Termination set to 75 Ohms
msd_rcv_odt150  DDR2 Input only; On-Die Termination set to 150 Ohms
msd_drv3_40120  DDR3 I/O, Zo=40-Ohms, external Rterm=120-Ohms, ODT disabled
msd_drv3_4060   DDR3 I/O, Zo=40-Ohms, external Rterm=60-Ohms, ODT disabled
msd_drv3_4040   DDR3 I/O, Zo=40-Ohms, external Rterm=40-Ohms, ODT disabled
msd_rcv3_odtoff DDR3 Input only; On-Die Termination off
msd_rcv3_odt40  DDR3 Input only; On-Die Termination set to 40 Ohms
msd_rcv3_odt60  DDR3 Input only; On-Die Termination set to 60 Ohms
msd_rcv3_odt120 DDR3 Input only; On-Die Termination set to 120 Ohms
[Model Selector]   MIIM
pru16sdgz   MDIO 3.3V
pru16sdgz_2v5  MDIO 2.5V
| Models and submodels in the file (39): pdidgz (Input), pddsdgz (Input), pdusdgz (Input), pru16sdgz (I/O), pru16sdgz_2v5 (I/O), pdt24dgz (3-state), obuf_1g (Output), ibuf_1g (Input), obuf_6g (Output), ibuf_6g (Input), ibuf_10g (Input), msd_drv_40150 (I/O), msd_drv_4075 (I/O), msd_drv_4050 (I/O), msd_rcv_odtoff (Input), msd_rcv_odt150 (Input), msd_rcv_odt75 (Input), msd_rcv_odt50 (Input), msd_drv3_40120 (I/O), msd_drv3_4060 (I/O), msd_drv3_4040 (I/O), msd_rcv3_odtoff (Input), msd_rcv3_odt120 (Input), msd_rcv3_odt60 (Input), msd_rcv3_odt40 (Input), msdd_drv_40150 (I/O), msdd_drv_4075 (I/O), msdd_drv_4050 (I/O), msdd_rcv_odtoff (Input), msdd_rcv_odt150 (Input), msdd_rcv_odt75 (Input), msdd_rcv_odt50 (Input), msdd_drv3_40120 (I/O), msdd_drv3_4060 (I/O), msdd_drv3_4040 (I/O), msdd_rcv3_odtoff (Input), msdd_rcv3_odt120 (Input), msdd_rcv3_odt60 (Input), msdd_rcv3_odt40 (Input)
